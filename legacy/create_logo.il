procedure((leCreatePgText \@optional LPP)
	let((cur_win rep rep_lib lname lpurp
		snapMode snapeShape text_string magAmount mtextString
		mlayer mSpaceBetween userGrid id_tech
	    )
	    (userGrid = ((leDisplayOptionsForm->xSnap)->value))
	    (libname = (dmGenOpenLibPathName))
	    (cln = caar(libname))
	    (dwindow = (geOpen ?lib cln ?cell "template"
		    ?view "layout" ?window
		    list((5:5)
			(250:150)
		    )
		))
	    printf("Character input is case insensitive but output will be UPPER CASE\n")
	    printf("Any Integer May Be Used With The Following Grids: (x/y Snap)\n")
	    printf("Multiples of 20 - Use Grid (x/y Snap of 1.0)\n")
	    printf("Multiples of 10 - Use Grid (x/y Snap of 0.5)\n")
	    printf("Multiples of  5 - Use Grid (x/y Snap of 0.25)\n")
	    printf("Even Multiples Other Than Above - Use a Grid (x/y Snap) of 0.1\n")
	    printf("Odd Multiples Other Than Above - Use a Grid (x/y Snap) of 0.05\n")
	    printf("Other Grids May Result In Line Mismatch\n")
	    (leCreatePgTextForm)
	    (hiZoomAbsoluteScale
		(hiGetCurrentWindow) 0.9
	    )
	    (geSelectAllFig)
	    (leHiMove)
	    (geDeselectAllFig)
	    (windowList = (hiGetWindowList))
	    (last = length(windowList))
	    (wid = nthelem(last windowList))
	    (geDiscardEdits wid)
	    (hiCloseWindow wid)
	)
    )
procedure((leCreatePgTextForm)
	(cur_win = (hiGetCurrentWindow))
	if(!cur_win then
	    printf("A cellView must be opened to place instances in.\n")
	    return(nil)
	)
	(rep = (geGetWindowRep cur_win))
	(rep_lib = (rep~>lib))
	(id_tech = (techGetTechFile rep_lib))
	(lay_list = (leGetValidLayerList id_tech))
	(LPP = car(lay_list))
	(text_string = (hiCreateStringField ?name
		'text_string ?prompt "Enter Text"
		?value "" ?defValue "" ?callback
		"" ?editable t
	    ))
	(magAmount = (hiCreateStringField ?name
		'magAmount ?prompt "Enter Mag"
		?value "" ?defValue "10" ?callback
		"" ?editable t
	    ))
	(layerField = (hiCreateLayerCyclicField id_tech "Layer for Polygon" "" lay_list
		LPP
	    ))
	(layerPurpose = (hiCreateStringField ?name
		'layerPurpose ?prompt "Purpose"
		?value "" ?defValue "drawing" ?callback
		"" ?editable t
	    ))
	(formId = (hiCreateForm
		'leCreatePgTextForm "GYW LOGO GENERATE" "leCreatePgTextCB()"
		list(list(text_string
			(0:10)
			(260:0) 80
		    )
		    list(magAmount
			(270:10)
			(160:0) 70
		    )
		    list(layerField
			(0:50)
			(260:35) 110
		    )
		    list(layerPurpose
			(270:50)
			(160:0) 70
		    )
		)
		""
	    ))
	(hiDisplayForm formId)
    )
procedure((leCreatePgTextCB)
	(text_string = stringToLower(((leCreatePgTextForm->text_string)->value)))
	(layer1 = nth(3
		((leCreatePgTextForm->hiLayerField)->value)
	    ))
	(mlayer = list(readstring(layer1)
		((leCreatePgTextForm->layerPurpose)->value)
	    ))
	printf("mlayer set to ")
	println(mlayer)
	(magAmount = float(evalstring(((leCreatePgTextForm->magAmount)->value))))
	(dspace = 2)
	(sspace = 5.0)
	(pntr = 0)
	(mtextString = parseString(text_string ""))
	(characterWidth = "norm")
	foreach(character mtextString
	    case(characterWidth
		("norm"
		    (pntr = (pntr + (magAmount * dspace)))
		)
		("wide"
		    (pntr = (pntr + (magAmount * dspace * 1.2)))
		)
		("narrow"
		    (pntr = (pntr + (magAmount * dspace * 0.6)))
		)
	    )
	    case(character
		("m"
		    (characterWidth = "wide")
		)
		("w"
		    (characterWidth = "wide")
		)
		(("i" "'" ":" ";" "("
			")" "!" "." "[" "]"
			"1" "\""
		    )
		    (characterWidth = "narrow")
		)
		(t
		    (characterWidth = "norm")
		)
	    )
	    case(character
		(" ")
		("a"
		    (dbCreatePolygon
			(getEditRep) mlayer
			(modifyCoords coords_listAMS1 pntr magAmount)
		    )
		    (dbCreatePolygon
			(getEditRep) mlayer
			(modifyCoords coords_listAMS2 pntr magAmount)
		    )
		    println((getEditRep))
		)
		("b"
		    (dbCreatePolygon
			(getEditRep) mlayer
			(modifyCoords coords_listBMS1 pntr magAmount)
		    )
		    (dbCreatePolygon
			(getEditRep) mlayer
			(modifyCoords coords_listBMS2 pntr magAmount)
		    )
		)
		("c"
		    (dbCreatePolygon
			(getEditRep) mlayer
			(modifyCoords coords_listCMS pntr magAmount)
		    )
		)
		("d"
		    (dbCreatePolygon
			(getEditRep) mlayer
			(modifyCoords coords_listDMS pntr magAmount)
		    )
		    (dbCreatePolygon
			(getEditRep) mlayer
			(modifyCoords coords_listDMS1 pntr magAmount)
		    )
		)
		("e"
		    (dbCreatePolygon
			(getEditRep) mlayer
			(modifyCoords coords_listEMS pntr magAmount)
		    )
		)
		("f"
		    (dbCreatePolygon
			(getEditRep) mlayer
			(modifyCoords coords_listFMS pntr magAmount)
		    )
		)
		("g"
		    (dbCreatePolygon
			(getEditRep) mlayer
			(modifyCoords coords_listGMS pntr magAmount)
		    )
		)
		("h"
		    (dbCreatePolygon
			(getEditRep) mlayer
			(modifyCoords coords_listHMS pntr magAmount)
		    )
		)
		("i"
		    (dbCreatePolygon
			(getEditRep) mlayer
			(modifyCoords coords_listIMS pntr magAmount)
		    )
		)
		("j"
		    (dbCreatePolygon
			(getEditRep) mlayer
			(modifyCoords coords_listJMS pntr magAmount)
		    )
		)
		("k"
		    (dbCreatePolygon
			(getEditRep) mlayer
			(modifyCoords coords_listKMS pntr magAmount)
		    )
		)
		("l"
		    (dbCreatePolygon
			(getEditRep) mlayer
			(modifyCoords coords_listLMS pntr magAmount)
		    )
		)
		("m"
		    (dbCreatePolygon
			(getEditRep) mlayer
			(modifyCoords coords_listMMS pntr magAmount)
		    )
		)
		("n"
		    (dbCreatePolygon
			(getEditRep) mlayer
			(modifyCoords coords_listNMS pntr magAmount)
		    )
		)
		("o"
		    (dbCreatePolygon
			(getEditRep) mlayer
			(modifyCoords coords_listOMS pntr magAmount)
		    )
		    (dbCreatePolygon
			(getEditRep) mlayer
			(modifyCoords coords_listOMS1 pntr magAmount)
		    )
		)
		("p"
		    (dbCreatePolygon
			(getEditRep) mlayer
			(modifyCoords coords_listPMS pntr magAmount)
		    )
		    (dbCreatePolygon
			(getEditRep) mlayer
			(modifyCoords coords_listPMS1 pntr magAmount)
		    )
		)
		("q"
		    (dbCreatePolygon
			(getEditRep) mlayer
			(modifyCoords coords_listQMS pntr magAmount)
		    )
		    (dbCreatePolygon
			(getEditRep) mlayer
			(modifyCoords coords_listQMS1 pntr magAmount)
		    )
		)
		("r"
		    (dbCreatePolygon
			(getEditRep) mlayer
			(modifyCoords coords_listRMS pntr magAmount)
		    )
		    (dbCreatePolygon
			(getEditRep) mlayer
			(modifyCoords coords_listRMS1 pntr magAmount)
		    )
		)
		("s"
		    (dbCreatePolygon
			(getEditRep) mlayer
			(modifyCoords coords_listSMS pntr magAmount)
		    )
		)
		("t"
		    (dbCreatePolygon
			(getEditRep) mlayer
			(modifyCoords coords_listTMS pntr magAmount)
		    )
		)
		("u"
		    (dbCreatePolygon
			(getEditRep) mlayer
			(modifyCoords coords_listUMS pntr magAmount)
		    )
		)
		("v"
		    (dbCreatePolygon
			(getEditRep) mlayer
			(modifyCoords coords_listVMS pntr magAmount)
		    )
		)
		("w"
		    (dbCreatePolygon
			(getEditRep) mlayer
			(modifyCoords coords_listWMS pntr magAmount)
		    )
		)
		("x"
		    (dbCreatePolygon
			(getEditRep) mlayer
			(modifyCoords coords_listXMS pntr magAmount)
		    )
		)
		("y"
		    (dbCreatePolygon
			(getEditRep) mlayer
			(modifyCoords coords_listYMS pntr magAmount)
		    )
		)
		("z"
		    (dbCreatePolygon
			(getEditRep) mlayer
			(modifyCoords coords_listZMS pntr magAmount)
		    )
		)
		("0"
		    (dbCreatePolygon
			(getEditRep) mlayer
			(modifyCoords coords_listMS0 pntr magAmount)
		    )
		    (dbCreatePolygon
			(getEditRep) mlayer
			(modifyCoords coords_listMS01 pntr magAmount)
		    )
		    (dbCreatePolygon
			(getEditRep) mlayer
			(modifyCoords coords_listMS02 pntr magAmount)
		    )
		)
		("1"
		    (dbCreatePolygon
			(getEditRep) mlayer
			(modifyCoords coords_listMS1 pntr magAmount)
		    )
		)
		("2"
		    (dbCreatePolygon
			(getEditRep) mlayer
			(modifyCoords coords_listMS2 pntr magAmount)
		    )
		)
		("3"
		    (dbCreatePolygon
			(getEditRep) mlayer
			(modifyCoords coords_listMS3 pntr magAmount)
		    )
		)
		("4"
		    (dbCreatePolygon
			(getEditRep) mlayer
			(modifyCoords coords_listMS4 pntr magAmount)
		    )
		)
		("5"
		    (dbCreatePolygon
			(getEditRep) mlayer
			(modifyCoords coords_listMS5 pntr magAmount)
		    )
		)
		("6"
		    (dbCreatePolygon
			(getEditRep) mlayer
			(modifyCoords coords_listMS6 pntr magAmount)
		    )
		    (dbCreatePolygon
			(getEditRep) mlayer
			(modifyCoords coords_listMS61 pntr magAmount)
		    )
		)
		("7"
		    (dbCreatePolygon
			(getEditRep) mlayer
			(modifyCoords coords_listMS7 pntr magAmount)
		    )
		)
		("8"
		    (dbCreatePolygon
			(getEditRep) mlayer
			(modifyCoords coords_listMS8 pntr magAmount)
		    )
		    (dbCreatePolygon
			(getEditRep) mlayer
			(modifyCoords coords_listMS81 pntr magAmount)
		    )
		)
		("9"
		    (dbCreatePolygon
			(getEditRep) mlayer
			(modifyCoords coords_listMS9 pntr magAmount)
		    )
		    (dbCreatePolygon
			(getEditRep) mlayer
			(modifyCoords coords_listMS91 pntr magAmount)
		    )
		)
		("."
		    (dbCreatePolygon
			(getEditRep) mlayer
			(modifyCoords coords_listPERMS pntr magAmount)
		    )
		)
		(","
		    (dbCreatePolygon
			(getEditRep) mlayer
			(modifyCoords coords_listCOMMS pntr magAmount)
		    )
		)
		("-"
		    (dbCreatePolygon
			(getEditRep) mlayer
			(modifyCoords coords_listDASMS pntr magAmount)
		    )
		)
		("/"
		    (dbCreatePolygon
			(getEditRep) mlayer
			(modifyCoords coords_listSLMS pntr magAmount)
		    )
		)
		("!"
		    (dbCreatePolygon
			(getEditRep) mlayer
			(modifyCoords coords_listEXMS pntr magAmount)
		    )
		    (dbCreatePolygon
			(getEditRep) mlayer
			(modifyCoords coords_listEXMS1 pntr magAmount)
		    )
		)
		("?"
		    (dbCreatePolygon
			(getEditRep) mlayer
			(modifyCoords coords_listQMMS pntr magAmount)
		    )
		    (dbCreatePolygon
			(getEditRep) mlayer
			(modifyCoords coords_listQMMS1 pntr magAmount)
		    )
		)
		(":"
		    (dbCreatePolygon
			(getEditRep) mlayer
			(modifyCoords coords_listCOLMS pntr magAmount)
		    )
		    (dbCreatePolygon
			(getEditRep) mlayer
			(modifyCoords coords_listCOLMS1 pntr magAmount)
		    )
		)
		(";"
		    (dbCreatePolygon
			(getEditRep) mlayer
			(modifyCoords coords_listSCMS pntr magAmount)
		    )
		    (dbCreatePolygon
			(getEditRep) mlayer
			(modifyCoords coords_listSCMS1 pntr magAmount)
		    )
		)
		("_"
		    (dbCreatePolygon
			(getEditRep) mlayer
			(modifyCoords coords_listUSMS pntr magAmount)
		    )
		)
		("="
		    (dbCreatePolygon
			(getEditRep) mlayer
			(modifyCoords coords_listEQMS pntr magAmount)
		    )
		    (dbCreatePolygon
			(getEditRep) mlayer
			(modifyCoords coords_listEQMS1 pntr magAmount)
		    )
		)
		("+"
		    (dbCreatePolygon
			(getEditRep) mlayer
			(modifyCoords coords_listPLUMS pntr magAmount)
		    )
		)
		("*"
		    (dbCreatePolygon
			(getEditRep) mlayer
			(modifyCoords coords_listASTMS pntr magAmount)
		    )
		)
		("'"
		    (dbCreatePolygon
			(getEditRep) mlayer
			(modifyCoords coords_listAPMS pntr magAmount)
		    )
		)
		("("
		    (dbCreatePolygon
			(getEditRep) mlayer
			(modifyCoords coords_listLPMS pntr magAmount)
		    )
		)
		(")"
		    (dbCreatePolygon
			(getEditRep) mlayer
			(modifyCoords coords_listRPMS pntr magAmount)
		    )
		)
		("["
		    (dbCreatePolygon
			(getEditRep) mlayer
			(modifyCoords coords_listLBMS pntr magAmount)
		    )
		)
		("]"
		    (dbCreatePolygon
			(getEditRep) mlayer
			(modifyCoords coords_listRBMS pntr magAmount)
		    )
		)
		("\\"
		    (dbCreatePolygon
			(getEditRep) mlayer
			(modifyCoords coords_listBSMS pntr magAmount)
		    )
		)
		("\""
		    (dbCreatePolygon
			(getEditRep) mlayer
			(modifyCoords coords_listQUMS pntr magAmount)
		    )
		    (dbCreatePolygon
			(getEditRep) mlayer
			(modifyCoords coords_listQUMS1 pntr magAmount)
		    )
		)
		("%"
		    (dbCreatePolygon
			(getEditRep) mlayer
			(modifyCoords coords_listPCTMS pntr magAmount)
		    )
		    (dbCreatePolygon
			(getEditRep) mlayer
			(modifyCoords coords_listPCTMS1 pntr magAmount)
		    )
		    (dbCreatePolygon
			(getEditRep) mlayer
			(modifyCoords coords_listPCTMS2 pntr magAmount)
		    )
		)
		("$"
		    (dbCreatePolygon
			(getEditRep) mlayer
			(modifyCoords coords_listDSMS pntr magAmount)
		    )
		    (dbCreatePolygon
			(getEditRep) mlayer
			(modifyCoords coords_listDSMS1 pntr magAmount)
		    )
		    (dbCreatePolygon
			(getEditRep) mlayer
			(modifyCoords coords_listDSMS2 pntr magAmount)
		    )
		)
		(t
		    printf("The '%s' character is not supported by leCreatePgText.\n" character)
		    printf("Skipping the '%s' character and leaving space for the user to insert it.\n" character)
		)
	    )
	)
    )
procedure((modifyCoords wholelist pntrNum magAmount)
	prog(nil
	    (newwholelist = list())
	    (finalnewwholelist = list())
	    foreach(sublistm wholelist
		(xnumberm = (pntrNum + ((car(sublistm) * magAmount * 1000.0) / 1000.0)))
		(ynumberm = ((cadr(sublistm) * magAmount * 1000.0) / 1000.0))
		(newsublistm = (geWindowToEditPoint
			(getCurrentWindow)
			list(xnumberm ynumberm)
		    ))
		(newwholelist = xcons(newwholelist newsublistm))
		(finalnewwholelist = reverse(newwholelist))
		(newsublistm = nil)
	    )
	    return(finalnewwholelist)
	)
    )
(coords_listAMS1 = list((0.8:0.6)
	    (0.8:1.0)
	    (0.4:1.0)
	    (0.4:1.4)
	    (0.6:1.6)
	    (0.8:1.6)
	    (0.8:2.0)
	    (0.4:2.0)
	    (0.0:1.6)
	    (0.0:0.0)
	    (0.4:0.0)
	    (0.4:0.6)
	    (0.8:0.6)
	))
(coords_listAMS2 = list((0.8:0.6)
	    (1.2:0.6)
	    (1.2:0.0)
	    (1.6:0.0)
	    (1.6:1.6)
	    (1.2:2.0)
	    (0.8:2.0)
	    (0.8:1.6)
	    (1.0:1.6)
	    (1.2:1.4)
	    (1.2:1.0)
	    (0.8:1.0)
	    (0.8:0.6)
	))
(coords_listBMS1 = list((0.8:0.0)
	    (0.8:0.4)
	    (0.4:0.4)
	    (0.4:0.8)
	    (0.8:0.8)
	    (0.8:1.2)
	    (0.4:1.2)
	    (0.4:1.6)
	    (0.8:1.6)
	    (0.8:2.0)
	    (0.0:2.0)
	    (0.0:0.0)
	    (0.8:0.0)
	))
(coords_listBMS2 = list((0.8:0.0)
	    (0.8:0.4)
	    (1.1:0.4)
	    (1.2:0.5)
	    (1.2:0.7)
	    (1.1:0.8)
	    (0.8:0.8)
	    (0.8:1.2)
	    (1.1:1.2)
	    (1.2:1.3)
	    (1.2:1.5)
	    (1.1:1.6)
	    (0.8:1.6)
	    (0.8:2.0)
	    (1.3:2.0)
	    (1.6:1.7)
	    (1.6:1.2)
	    (1.4:1.0)
	    (1.6:0.8)
	    (1.6:0.3)
	    (1.3:0.0)
	    (0.8:0.0)
	))
(coords_listCMS = list((0.0:0.4)
	    (0.4:0.0)
	    (1.2:0.0)
	    (1.6:0.4)
	    (1.6:0.6)
	    (1.2:0.6)
	    (1.0:0.4)
	    (0.6:0.4)
	    (0.4:0.6)
	    (0.4:1.4)
	    (0.6:1.6)
	    (1.0:1.6)
	    (1.2:1.4)
	    (1.6:1.4)
	    (1.6:1.6)
	    (1.2:2.0)
	    (0.4:2.0)
	    (0.0:1.6)
	    (0.0:0.4)
	))
(coords_listDMS = list((0.8:0.0)
	    (0.8:0.4)
	    (0.4:0.4)
	    (0.4:1.6)
	    (0.8:1.6)
	    (0.8:2.0)
	    (0.0:2.0)
	    (0.0:0.0)
	    (0.8:0.0)
	))
(coords_listDMS1 = list((0.8:0.0)
	    (1.2:0.0)
	    (1.6:0.4)
	    (1.6:1.6)
	    (1.2:2.0)
	    (0.8:2.0)
	    (0.8:1.6)
	    (1.0:1.6)
	    (1.2:1.4)
	    (1.2:0.6)
	    (1.0:0.4)
	    (0.8:0.4)
	    (0.8:0.0)
	))
(coords_listEMS = list((0.0:0.0)
	    (1.6:0.0)
	    (1.6:0.4)
	    (0.4:0.4)
	    (0.4:0.8)
	    (1.2:0.8)
	    (1.2:1.2)
	    (0.4:1.2)
	    (0.4:1.6)
	    (1.6:1.6)
	    (1.6:2.0)
	    (0.0:2.0)
	    (0.0:0.0)
	))
(coords_listFMS = list((0.0:0.0)
	    (0.4:0.0)
	    (0.4:0.8)
	    (1.2:0.8)
	    (1.2:1.2)
	    (0.4:1.2)
	    (0.4:1.6)
	    (1.6:1.6)
	    (1.6:2.0)
	    (0.0:2.0)
	    (0.0:0.0)
	))
(coords_listGMS = list((0.4:0.0)
	    (1.2:0.0)
	    (1.6:0.4)
	    (1.6:1.0)
	    (0.8:1.0)
	    (0.8:0.7)
	    (1.2:0.7)
	    (1.2:0.6)
	    (1.0:0.4)
	    (0.6:0.4)
	    (0.4:0.6)
	    (0.4:1.4)
	    (0.6:1.6)
	    (1.0:1.6)
	    (1.2:1.4)
	    (1.6:1.4)
	    (1.6:1.6)
	    (1.2:2.0)
	    (0.4:2.0)
	    (0.0:1.6)
	    (0.0:0.4)
	    (0.4:0.0)
	))
(coords_listHMS = list((0.0:0.0)
	    (0.4:0.0)
	    (0.4:0.8)
	    (1.2:0.8)
	    (1.2:0.0)
	    (1.6:0.0)
	    (1.6:2.0)
	    (1.2:2.0)
	    (1.2:1.2)
	    (0.4:1.2)
	    (0.4:2.0)
	    (0.0:2.0)
	    (0.0:0.0)
	))
(coords_listIMS = list((0.0:0.0)
	    (0.8:0.0)
	    (0.8:0.4)
	    (0.6:0.4)
	    (0.6:1.6)
	    (0.8:1.6)
	    (0.8:2.0)
	    (0.0:2.0)
	    (0.0:1.6)
	    (0.2:1.6)
	    (0.2:0.4)
	    (0.0:0.4)
	    (0.0:0.0)
	))
(coords_listJMS = list((0.4:0.0)
	    (1.2:0.0)
	    (1.6:0.4)
	    (1.6:2.0)
	    (1.2:2.0)
	    (1.2:0.6)
	    (1.0:0.4)
	    (0.6:0.4)
	    (0.4:0.6)
	    (0.4:0.7)
	    (0.0:0.7)
	    (0.0:0.4)
	    (0.4:0.0)
	))
(coords_listKMS = list((0.0:0.0)
	    (0.4:0.0)
	    (0.4:0.8)
	    (0.6:0.8)
	    (1.2:0.2)
	    (1.2:0.0)
	    (1.6:0.0)
	    (1.6:0.4)
	    (1.0:1.0)
	    (1.6:1.6)
	    (1.6:2.0)
	    (1.2:2.0)
	    (1.2:1.8)
	    (0.6:1.2)
	    (0.4:1.2)
	    (0.4:2.0)
	    (0.0:2.0)
	    (0.0:0.0)
	))
(coords_listLMS = list((0.0:0.0)
	    (1.6:0.0)
	    (1.6:0.4)
	    (0.4:0.4)
	    (0.4:2.0)
	    (0.0:2.0)
	    (0.0:0.0)
	))
(coords_listMMS = list((0.0:0.0)
	    (0.4:0.0)
	    (0.4:1.2)
	    (0.6:1.2)
	    (1.0:0.8)
	    (1.4:1.2)
	    (1.6:1.2)
	    (1.6:0.0)
	    (2.0:0.0)
	    (2.0:2.0)
	    (1.6:2.0)
	    (1.0:1.4)
	    (0.4:2.0)
	    (0.0:2.0)
	    (0.0:0.0)
	))
(coords_listNMS = list((0.0:0.0)
	    (0.4:0.0)
	    (0.4:1.0)
	    (0.5:1.0)
	    (1.5:0.0)
	    (1.6:0.0)
	    (1.6:2.0)
	    (1.2:2.0)
	    (1.2:1.0)
	    (1.1:1.0)
	    (0.1:2.0)
	    (0.0:2.0)
	    (0.0:0.0)
	))
(coords_listOMS = list((0.8:0.0)
	    (0.8:0.4)
	    (0.6:0.4)
	    (0.4:0.6)
	    (0.4:1.4)
	    (0.6:1.6)
	    (0.8:1.6)
	    (0.8:2.0)
	    (0.4:2.0)
	    (0.0:1.6)
	    (0.0:0.4)
	    (0.4:0.0)
	    (0.8:0.0)
	))
(coords_listOMS1 = list((0.8:0.0)
	    (1.2:0.0)
	    (1.6:0.4)
	    (1.6:1.6)
	    (1.2:2.0)
	    (0.8:2.0)
	    (0.8:1.6)
	    (1.0:1.6)
	    (1.2:1.4)
	    (1.2:0.6)
	    (1.0:0.4)
	    (0.8:0.4)
	    (0.8:0.0)
	))
(coords_listPMS = list((0.8:0.8)
	    (0.8:1.2)
	    (0.4:1.2)
	    (0.4:1.6)
	    (0.8:1.6)
	    (0.8:2.0)
	    (0.0:2.0)
	    (0.0:0.0)
	    (0.4:0.0)
	    (0.4:0.8)
	    (0.8:0.8)
	))
(coords_listPMS1 = list((0.8:0.8)
	    (1.3:0.8)
	    (1.6:1.1)
	    (1.6:1.7)
	    (1.3:2.0)
	    (0.8:2.0)
	    (0.8:1.6)
	    (1.1:1.6)
	    (1.2:1.5)
	    (1.2:1.3)
	    (1.1:1.2)
	    (0.8:1.2)
	    (0.8:0.8)
	))
(coords_listQMS = list((0.8:0.0)
	    (0.8:0.4)
	    (0.6:0.4)
	    (0.4:0.6)
	    (0.4:1.4)
	    (0.6:1.6)
	    (0.8:1.6)
	    (0.8:2.0)
	    (0.4:2.0)
	    (0.0:1.6)
	    (0.0:0.4)
	    (0.4:0.0)
	    (0.8:0.0)
	))
(coords_listQMS1 = list((0.8:0.0)
	    (1.2:0.0)
	    (1.4:-0.2)
	    (1.8:0.2)
	    (1.6:0.4)
	    (1.6:1.6)
	    (1.2:2.0)
	    (0.8:2.0)
	    (0.8:1.6)
	    (1.0:1.6)
	    (1.2:1.4)
	    (1.2:0.6)
	    (1.0:0.4)
	    (0.8:0.4)
	    (0.8:0.0)
	))
(coords_listRMS = list((0.6:0.8)
	    (0.6:1.2)
	    (0.4:1.2)
	    (0.4:1.6)
	    (0.6:1.6)
	    (0.6:2.0)
	    (0.0:2.0)
	    (0.0:0.0)
	    (0.4:0.0)
	    (0.4:0.8)
	    (0.6:0.8)
	))
(coords_listRMS1 = list((0.6:0.8)
	    (0.8:0.8)
	    (1.2:0.4)
	    (1.2:0.0)
	    (1.6:0.0)
	    (1.6:0.5)
	    (1.3:0.8)
	    (1.6:1.1)
	    (1.6:1.7)
	    (1.3:2.0)
	    (0.6:2.0)
	    (0.6:1.6)
	    (1.1:1.6)
	    (1.2:1.5)
	    (1.2:1.3)
	    (1.1:1.2)
	    (0.6:1.2)
	    (0.6:0.8)
	))
(coords_listSMS = list((0.3:0.0)
	    (1.3:0.0)
	    (1.6:0.3)
	    (1.6:0.9)
	    (1.3:1.2)
	    (0.5:1.2)
	    (0.4:1.3)
	    (0.4:1.5)
	    (0.5:1.6)
	    (1.1:1.6)
	    (1.2:1.5)
	    (1.6:1.5)
	    (1.6:1.7)
	    (1.3:2.0)
	    (0.3:2.0)
	    (0.0:1.7)
	    (0.0:1.1)
	    (0.3:0.8)
	    (1.1:0.8)
	    (1.2:0.7)
	    (1.2:0.5)
	    (1.1:0.4)
	    (0.5:0.4)
	    (0.4:0.5)
	    (0.0:0.5)
	    (0.0:0.3)
	    (0.3:0.0)
	))
(coords_listTMS = list((0.6:0.0)
	    (1.0:0.0)
	    (1.0:1.6)
	    (1.6:1.6)
	    (1.6:2.0)
	    (0.0:2.0)
	    (0.0:1.6)
	    (0.6:1.6)
	    (0.6:0.0)
	))
(coords_listUMS = list((0.4:0.0)
	    (1.2:0.0)
	    (1.6:0.4)
	    (1.6:2.0)
	    (1.2:2.0)
	    (1.2:0.6)
	    (1.0:0.4)
	    (0.6:0.4)
	    (0.4:0.6)
	    (0.4:2.0)
	    (0.0:2.0)
	    (0.0:0.4)
	    (0.4:0.0)
	))
(coords_listVMS = list((0.7:0.0)
	    (0.9:0.0)
	    (1.6:0.7)
	    (1.6:2.0)
	    (1.2:2.0)
	    (1.2:0.9)
	    (0.8:0.5)
	    (0.4:0.9)
	    (0.4:2.0)
	    (0.0:2.0)
	    (0.0:0.7)
	    (0.7:0.0)
	))
(coords_listWMS = list((0.0:0.0)
	    (0.4:0.0)
	    (1.0:0.6)
	    (1.6:0.0)
	    (2.0:0.0)
	    (2.0:2.0)
	    (1.6:2.0)
	    (1.6:0.8)
	    (1.4:0.8)
	    (1.0:1.2)
	    (0.6:0.8)
	    (0.4:0.8)
	    (0.4:2.0)
	    (0.0:2.0)
	    (0.0:0.0)
	))
(coords_listXMS = list((0.0:0.0)
	    (0.4:0.0)
	    (0.4:0.4)
	    (0.8:0.8)
	    (1.2:0.4)
	    (1.2:0.0)
	    (1.6:0.0)
	    (1.6:0.6)
	    (1.2:1.0)
	    (1.6:1.4)
	    (1.6:2.0)
	    (1.2:2.0)
	    (1.2:1.6)
	    (0.8:1.2)
	    (0.4:1.6)
	    (0.4:2.0)
	    (0.0:2.0)
	    (0.0:1.4)
	    (0.4:1.0)
	    (0.0:0.6)
	    (0.0:0.0)
	))
(coords_listYMS = list((0.6:0.0)
	    (1.0:0.0)
	    (1.0:0.7)
	    (1.6:1.3)
	    (1.6:2.0)
	    (1.2:2.0)
	    (1.2:1.5)
	    (0.8:1.1)
	    (0.4:1.5)
	    (0.4:2.0)
	    (0.0:2.0)
	    (0.0:1.3)
	    (0.6:0.7)
	    (0.6:0.0)
	))
(coords_listZMS = list((0.0:0.0)
	    (1.6:0.0)
	    (1.6:0.4)
	    (0.6:0.4)
	    (0.6:0.5)
	    (1.6:1.5)
	    (1.6:2.0)
	    (0.0:2.0)
	    (0.0:1.6)
	    (1.0:1.6)
	    (1.0:1.5)
	    (0.0:0.5)
	    (0.0:0.0)
	))
(coords_listMS0 = list((0.8:0.0)
	    (0.8:0.4)
	    (0.6:0.4)
	    (0.4:0.6)
	    (0.4:1.4)
	    (0.6:1.6)
	    (0.8:1.6)
	    (0.8:2.0)
	    (0.4:2.0)
	    (0.0:1.6)
	    (0.0:0.4)
	    (0.4:0.0)
	    (0.8:0.0)
	))
(coords_listMS01 = list((0.8:0.0)
	    (1.2:0.0)
	    (1.6:0.4)
	    (1.6:1.6)
	    (1.2:2.0)
	    (0.8:2.0)
	    (0.8:1.6)
	    (1.0:1.6)
	    (1.2:1.4)
	    (1.2:0.6)
	    (1.0:0.4)
	    (0.8:0.4)
	    (0.8:0.0)
	))
(coords_listMS02 = list((0.7:0.7)
	    (1.1:1.1)
	    (0.9:1.3)
	    (0.5:0.9)
	    (0.7:0.7)
	))
(coords_listMS1 = list((0.0:0.0)
	    (0.8:0.0)
	    (0.8:0.4)
	    (0.6:0.4)
	    (0.6:2.0)
	    (0.2:2.0)
	    (0.0:1.8)
	    (0.0:1.6)
	    (0.2:1.6)
	    (0.2:0.4)
	    (0.0:0.4)
	    (0.0:0.0)
	))
(coords_listMS2 = list((0.0:0.0)
	    (1.6:0.0)
	    (1.6:0.4)
	    (0.4:0.4)
	    (0.4:0.6)
	    (0.5:0.7)
	    (1.3:0.7)
	    (1.6:1.0)
	    (1.6:1.7)
	    (1.3:2.0)
	    (0.3:2.0)
	    (0.0:1.7)
	    (0.0:1.5)
	    (0.4:1.5)
	    (0.5:1.6)
	    (1.1:1.6)
	    (1.2:1.5)
	    (1.2:1.2)
	    (1.1:1.1)
	    (0.3:1.1)
	    (0.0:0.8)
	    (0.0:0.0)
	))
(coords_listMS3 = list((0.3:0.0)
	    (1.3:0.0)
	    (1.6:0.3)
	    (1.6:0.8)
	    (1.4:1.0)
	    (1.6:1.2)
	    (1.6:1.7)
	    (1.3:2.0)
	    (0.3:2.0)
	    (0.0:1.7)
	    (0.0:1.5)
	    (0.4:1.5)
	    (0.5:1.6)
	    (1.1:1.6)
	    (1.2:1.5)
	    (1.2:1.3)
	    (1.1:1.2)
	    (0.7:1.2)
	    (0.7:0.8)
	    (1.1:0.8)
	    (1.2:0.7)
	    (1.2:0.5)
	    (1.1:0.4)
	    (0.5:0.4)
	    (0.4:0.5)
	    (0.0:0.5)
	    (0.0:0.3)
	    (0.3:0.0)
	))
(coords_listMS4 = list((0.0:0.8)
	    (1.0:0.8)
	    (1.0:0.0)
	    (1.4:0.0)
	    (1.4:0.8)
	    (1.6:0.8)
	    (1.6:1.2)
	    (1.4:1.2)
	    (1.4:2.0)
	    (1.0:2.0)
	    (1.0:1.2)
	    (0.4:1.2)
	    (0.4:2.0)
	    (0.0:2.0)
	    (0.0:0.8)
	))
(coords_listMS5 = list((0.3:0.0)
	    (1.3:0.0)
	    (1.6:0.3)
	    (1.6:1.0)
	    (1.3:1.3)
	    (0.5:1.3)
	    (0.4:1.4)
	    (0.4:1.6)
	    (1.6:1.6)
	    (1.6:2.0)
	    (0.0:2.0)
	    (0.0:1.2)
	    (0.3:0.9)
	    (1.1:0.9)
	    (1.2:0.8)
	    (1.2:0.5)
	    (1.1:0.4)
	    (0.5:0.4)
	    (0.4:0.5)
	    (0.0:0.5)
	    (0.0:0.3)
	    (0.3:0.0)
	))
(coords_listMS6 = list((0.8:0.0)
	    (0.8:0.4)
	    (0.5:0.4)
	    (0.4:0.5)
	    (0.4:0.7)
	    (0.5:0.8)
	    (0.8:0.8)
	    (0.8:1.2)
	    (0.4:1.2)
	    (0.4:1.5)
	    (0.5:1.6)
	    (1.1:1.6)
	    (1.2:1.5)
	    (1.6:1.5)
	    (1.6:1.7)
	    (1.3:2.0)
	    (0.3:2.0)
	    (0.0:1.7)
	    (0.0:0.3)
	    (0.3:0.0)
	    (0.8:0.0)
	))
(coords_listMS61 = list((0.8:0.0)
	    (1.3:0.0)
	    (1.6:0.3)
	    (1.6:0.9)
	    (1.3:1.2)
	    (0.8:1.2)
	    (0.8:0.8)
	    (1.1:0.8)
	    (1.2:0.7)
	    (1.2:0.5)
	    (1.1:0.4)
	    (0.8:0.4)
	    (0.8:0.0)
	))
(coords_listMS7 = list((0.6:0.0)
	    (1.0:0.0)
	    (1.0:0.8)
	    (1.6:1.4)
	    (1.6:2.0)
	    (0.0:2.0)
	    (0.0:1.6)
	    (1.2:1.6)
	    (1.2:1.5)
	    (0.6:0.9)
	    (0.6:0.0)
	))
(coords_listMS8 = list((0.8:0.0)
	    (0.8:0.4)
	    (0.5:0.4)
	    (0.4:0.5)
	    (0.4:0.7)
	    (0.5:0.8)
	    (0.8:0.8)
	    (0.8:1.2)
	    (0.5:1.2)
	    (0.4:1.3)
	    (0.4:1.5)
	    (0.5:1.6)
	    (0.8:1.6)
	    (0.8:2.0)
	    (0.3:2.0)
	    (0.0:1.7)
	    (0.0:1.2)
	    (0.2:1.0)
	    (0.0:0.8)
	    (0.0:0.3)
	    (0.3:0.0)
	    (0.8:0.0)
	))
(coords_listMS81 = list((0.8:0.0)
	    (1.3:0.0)
	    (1.6:0.3)
	    (1.6:0.8)
	    (1.4:1.0)
	    (1.6:1.2)
	    (1.6:1.7)
	    (1.3:2.0)
	    (0.8:2.0)
	    (0.8:1.6)
	    (1.1:1.6)
	    (1.2:1.5)
	    (1.2:1.3)
	    (1.1:1.2)
	    (0.8:1.2)
	    (0.8:0.8)
	    (1.1:0.8)
	    (1.2:0.7)
	    (1.2:0.5)
	    (1.1:0.4)
	    (0.8:0.4)
	    (0.8:0.0)
	))
(coords_listMS9 = list((0.8:1.6)
	    (0.8:2.0)
	    (0.3:2.0)
	    (0.0:1.7)
	    (0.0:1.1)
	    (0.3:0.8)
	    (0.8:0.8)
	    (0.8:1.2)
	    (0.5:1.2)
	    (0.4:1.3)
	    (0.4:1.5)
	    (0.5:1.6)
	    (0.8:1.6)
	))
(coords_listMS91 = list((0.8:1.6)
	    (1.1:1.6)
	    (1.2:1.5)
	    (1.2:1.3)
	    (1.1:1.2)
	    (0.8:1.2)
	    (0.8:0.8)
	    (1.2:0.8)
	    (1.2:0.5)
	    (1.1:0.4)
	    (0.5:0.4)
	    (0.4:0.5)
	    (0.0:0.5)
	    (0.0:0.3)
	    (0.3:0.0)
	    (1.3:0.0)
	    (1.6:0.3)
	    (1.6:1.7)
	    (1.3:2.0)
	    (0.8:2.0)
	    (0.8:1.6)
	))
(coords_listPERMS = list((0.1:0.1)
	    (0.3:0.1)
	    (0.4:0.2)
	    (0.4:0.4)
	    (0.3:0.5)
	    (0.1:0.5)
	    (0.0:0.4)
	    (0.0:0.2)
	    (0.1:0.1)
	))
(coords_listCOMMS = list((0.1:0.1)
	    (-0.1:-0.1)
	    (0.0:-0.2)
	    (0.4:0.2)
	    (0.4:0.4)
	    (0.3:0.5)
	    (0.1:0.5)
	    (0.0:0.4)
	    (0.0:0.2)
	    (0.1:0.1)
	))
(coords_listDASMS = list((0.0:0.9)
	    (1.6:0.9)
	    (1.6:1.2)
	    (0.0:1.2)
	    (0.0:0.9)
	))
(coords_listSLMS = list((0.2:0.2)
	    (1.6:1.6)
	    (1.4:1.8)
	    (0.0:0.4)
	    (0.2:0.2)
	))
(coords_listEXMS = list((0.1:0.8)
	    (0.3:0.8)
	    (0.4:0.9)
	    (0.4:1.9)
	    (0.3:2.0)
	    (0.1:2.0)
	    (0.0:1.9)
	    (0.0:0.9)
	    (0.1:0.8)
	))
(coords_listEXMS1 = list((0.1:0.0)
	    (0.3:0.0)
	    (0.4:0.1)
	    (0.4:0.3)
	    (0.3:0.4)
	    (0.1:0.4)
	    (0.0:0.3)
	    (0.0:0.1)
	    (0.1:0.0)
	))
(coords_listQMMS = list((0.5:0.6)
	    (0.9:0.6)
	    (1.0:0.7)
	    (1.2:0.7)
	    (1.5:1.0)
	    (1.5:1.7)
	    (1.2:2.0)
	    (0.3:2.0)
	    (0.0:1.7)
	    (0.0:1.4)
	    (0.4:1.4)
	    (0.4:1.5)
	    (0.5:1.6)
	    (1.0:1.6)
	    (1.1:1.5)
	    (1.1:1.2)
	    (1.0:1.1)
	    (0.8:1.1)
	    (0.5:0.8)
	    (0.5:0.6)
	))
(coords_listQMMS1 = list((0.6:0.0)
	    (0.8:0.0)
	    (0.9:0.1)
	    (0.9:0.3)
	    (0.8:0.4)
	    (0.6:0.4)
	    (0.5:0.3)
	    (0.5:0.1)
	    (0.6:0.0)
	))
(coords_listCOLMS = list((0.1:0.0)
	    (0.3:0.0)
	    (0.4:0.1)
	    (0.4:0.3)
	    (0.3:0.4)
	    (0.1:0.4)
	    (0.0:0.3)
	    (0.0:0.1)
	    (0.1:0.0)
	))
(coords_listCOLMS1 = list((0.1:0.8)
	    (0.3:0.8)
	    (0.4:0.9)
	    (0.4:1.1)
	    (0.3:1.2)
	    (0.1:1.2)
	    (0.0:1.1)
	    (0.0:0.9)
	    (0.1:0.8)
	))
(coords_listSCMS = list((0.1:0.0)
	    (-0.1:-0.2)
	    (0.0:-0.3)
	    (0.4:0.1)
	    (0.4:0.3)
	    (0.3:0.4)
	    (0.1:0.4)
	    (0.0:0.3)
	    (0.0:0.1)
	    (0.1:0.0)
	))
(coords_listSCMS1 = list((0.1:0.8)
	    (0.3:0.8)
	    (0.4:0.9)
	    (0.4:1.1)
	    (0.3:1.2)
	    (0.1:1.2)
	    (0.0:1.1)
	    (0.0:0.9)
	    (0.1:0.8)
	))
(coords_listUSMS = list((0.0:0.0)
	    (1.6:0.0)
	    (1.6:0.3)
	    (0.0:0.3)
	    (0.0:0.0)
	))
(coords_listEQMS = list((0.0:0.5)
	    (1.4:0.5)
	    (1.4:0.8)
	    (0.0:0.8)
	    (0.0:0.5)
	))
(coords_listEQMS1 = list((0.0:1.2)
	    (1.4:1.2)
	    (1.4:1.5)
	    (0.0:1.5)
	    (0.0:1.2)
	))
(coords_listPLUMS = list((0.0:0.9)
	    (0.6:0.9)
	    (0.6:0.3)
	    (0.9:0.3)
	    (0.9:0.9)
	    (1.5:0.9)
	    (1.5:1.2)
	    (0.9:1.2)
	    (0.9:1.8)
	    (0.6:1.8)
	    (0.6:1.2)
	    (0.0:1.2)
	    (0.0:0.9)
	))
(coords_listASTMS = list((0.0:0.9)
	    (0.5:0.9)
	    (0.1:0.5)
	    (0.2:0.4)
	    (0.6:0.8)
	    (0.6:0.3)
	    (0.8:0.3)
	    (0.8:0.8)
	    (1.2:0.4)
	    (1.3:0.5)
	    (0.9:0.9)
	    (1.4:0.9)
	    (1.4:1.1)
	    (0.9:1.1)
	    (1.3:1.5)
	    (1.2:1.6)
	    (0.8:1.2)
	    (0.8:1.7)
	    (0.6:1.7)
	    (0.6:1.2)
	    (0.2:1.6)
	    (0.1:1.5)
	    (0.5:1.1)
	    (0.0:1.1)
	    (0.0:0.9)
	))
(coords_listAPMS = list((0.0:1.7)
	    (0.1:1.6)
	    (-0.1:1.4)
	    (0.0:1.3)
	    (0.4:1.7)
	    (0.4:1.9)
	    (0.3:2.0)
	    (0.1:2.0)
	    (0.0:1.9)
	    (0.0:1.7)
	))
(coords_listLPMS = list((0.4:-0.2)
	    (0.7:-0.2)
	    (0.7:0.1)
	    (0.5:0.1)
	    (0.3:0.3)
	    (0.3:1.7)
	    (0.5:1.9)
	    (0.7:1.9)
	    (0.7:2.2)
	    (0.4:2.2)
	    (0.0:1.8)
	    (0.0:0.2)
	    (0.4:-0.2)
	))
(coords_listRPMS = list((0.0:-0.2)
	    (0.3:-0.2)
	    (0.7:0.2)
	    (0.7:1.8)
	    (0.3:2.2)
	    (0.0:2.2)
	    (0.0:1.9)
	    (0.2:1.9)
	    (0.4:1.7)
	    (0.4:0.3)
	    (0.2:0.1)
	    (0.0:0.1)
	    (0.0:-0.2)
	))
(coords_listLBMS = list((0.0:-0.2)
	    (0.7:-0.2)
	    (0.7:0.1)
	    (0.3:0.1)
	    (0.3:1.9)
	    (0.7:1.9)
	    (0.7:2.2)
	    (0.0:2.2)
	    (0.0:-0.2)
	))
(coords_listRBMS = list((0.0:-0.2)
	    (0.7:-0.2)
	    (0.7:2.2)
	    (0.0:2.2)
	    (0.0:1.9)
	    (0.4:1.9)
	    (0.4:0.1)
	    (0.0:0.1)
	    (0.0:-0.2)
	))
(coords_listBSMS = list((1.4:0.2)
	    (1.6:0.4)
	    (0.2:1.8)
	    (0.0:1.6)
	    (1.4:0.2)
	))
(coords_listQUMS = list((0.0:1.4)
	    (0.3:1.4)
	    (0.3:2.2)
	    (0.0:2.2)
	    (0.0:1.4)
	))
(coords_listQUMS1 = list((0.6:1.4)
	    (0.9:1.4)
	    (0.9:2.2)
	    (0.6:2.2)
	    (0.6:1.4)
	))
(coords_listPCTMS = list((0.2:0.2)
	    (1.6:1.6)
	    (1.4:1.8)
	    (0.0:0.4)
	    (0.2:0.2)
	))
(coords_listPCTMS1 = list((0.1:1.4)
	    (0.3:1.4)
	    (0.4:1.5)
	    (0.4:1.7)
	    (0.3:1.8)
	    (0.1:1.8)
	    (0.0:1.7)
	    (0.0:1.5)
	    (0.1:1.4)
	))
(coords_listPCTMS2 = list((1.3:0.2)
	    (1.5:0.2)
	    (1.6:0.3)
	    (1.6:0.5)
	    (1.5:0.6)
	    (1.3:0.6)
	    (1.2:0.5)
	    (1.2:0.3)
	    (1.3:0.2)
	))
(coords_listDSMS = list((0.0:1.4)
	    (0.2:1.4)
	    (0.2:1.7)
	    (0.3:1.8)
	    (0.7:1.8)
	    (0.7:1.4)
	    (0.9:1.4)
	    (0.9:1.8)
	    (1.3:1.8)
	    (1.4:1.7)
	    (1.6:1.7)
	    (1.6:1.8)
	    (1.4:2.0)
	    (0.9:2.0)
	    (0.9:2.2)
	    (0.7:2.2)
	    (0.7:2.0)
	    (0.2:2.0)
	    (0.0:1.8)
	    (0.0:1.4)
	))
(coords_listDSMS1 = list((0.0:1.4)
	    (0.0:1.1)
	    (0.2:0.9)
	    (0.7:0.9)
	    (0.7:0.6)
	    (0.9:0.6)
	    (0.9:0.9)
	    (1.3:0.9)
	    (1.4:0.8)
	    (1.4:0.6)
	    (1.6:0.6)
	    (1.6:0.9)
	    (1.4:1.1)
	    (0.9:1.1)
	    (0.9:1.4)
	    (0.7:1.4)
	    (0.7:1.1)
	    (0.3:1.1)
	    (0.2:1.2)
	    (0.2:1.4)
	    (0.0:1.4)
	))
(coords_listDSMS2 = list((0.2:0.0)
	    (0.7:0.0)
	    (0.7:-0.2)
	    (0.9:-0.2)
	    (0.9:0.0)
	    (1.4:0.0)
	    (1.6:0.2)
	    (1.6:0.6)
	    (1.4:0.6)
	    (1.4:0.3)
	    (1.3:0.2)
	    (0.9:0.2)
	    (0.9:0.6)
	    (0.7:0.6)
	    (0.7:0.2)
	    (0.3:0.2)
	    (0.2:0.3)
	    (0.0:0.3)
	    (0.0:0.2)
	    (0.2:0.0)
	))
